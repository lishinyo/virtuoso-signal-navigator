; SPDX-License-Identifier: MIT
; EXPLICIT WRITE-ENABLED TEST FIXTURE. New disposable LSN_DEMO_PAD_ library only.
; Attaches this NEW library to a caller-selected existing technology read-only.
; Uses existing PAD masters by reference; never saves/modifies their databases.
procedure(lsnPadFixturePort(cv name layer y @optional (xOffset 0.0))
  let((net term fig)
    net=dbCreateNet(cv name) term=dbCreateTerm(net name "inputOutput")
    foreach(x list(0.0 10.0)
      fig=dbCreateRect(cv list(layer "drawing") list(list(xOffset+x y-0.3) list(xOffset+x+1.0 y+0.3)))
      dbCreatePin(net fig sprintf(nil "%s_%g" name x) term))
    dbAddFigToNet(dbCreateRect(cv list(layer "drawing") list(list(xOffset y-0.3) list(xOffset+11 y+0.3))) net)
    net))

procedure(lsnPadFixtureSource(lib cell names)
  let((cv net)
    cv=dbOpenCellViewByType(lib cell "schematic" "schematic" "a")
    foreach(name names net=dbCreateNet(cv name) dbCreateTerm(net name "inputOutput"))
    dbSave(cv) dbClose(cv)))

procedure(lsnPadCreateFixture(libName libPath techLib)
  let((lib analog digital vdd ground multi core top bare parent net term fig pad)
    unless(stringp(libName) && substring(libName 1 13)=="LSN_DEMO_PAD_" &&
      stringp(libPath) && substring(libPath 1 1)=="/"
      error("Use a new LSN_DEMO_PAD_ library and a new absolute directory.\n"))
    when(ddGetObj(libName) || isDir(libPath) || isFile(libPath) error("Fixture already exists; no overwrite.\n"))
    lib=ddCreateLib(libName libPath)
    unless(lib && techBindTechFile(lib techLib "tech.db") error("Cannot attach new fixture library to the requested technology.\n"))
    analog=dbOpenCellViewByType("DBH_ANALOG_PAD" "IOPAD" "layout" "" "r")
    digital=dbOpenCellViewByType("DBH_1830AN18BA_AN18GPIO5V_ISO_MINI_75U" "PH18C0810_ISO_75" "layout" "" "r")
    vdd=dbOpenCellViewByType("DBH_ANALOG_PAD" "VDDPAD" "layout" "" "r")
    ground=dbOpenCellViewByType("DBH_ANALOG_PAD" "GNDPAD" "layout" "" "r")
    unless(analog && digital && vdd && ground error("This optional integration fixture requires the documented PAD libraries.\n"))
    multi=dbOpenCellViewByType(libName "multi_access_pad" "layout" "maskLayout" "a")
    net=dbCreateNet(multi "IO") term=dbCreateTerm(net "IO" "inputOutput")
    foreach(y list(0.5 20.5)
      fig=dbCreateRect(multi list("MET6" "drawing") list(list(0 y-0.5) list(1 y+0.5)))
      dbCreatePin(net fig sprintf(nil "IO_%g" y) term))
    dbSave(multi)
    lsnPadRegisterProfile(libName "multi_access_pad" list(list("IO" "label" list("IO"))))
    top=dbOpenCellViewByType(libName "pad_top" "layout" "maskLayout" "a")
    lsnPadFixturePort(top "A" "MET6" 39.0)
    ; Move digital test ports to the left of the real GPIO terminal row.
    lsnPadFixturePort(top "DATA" "MET2" 100.22 280.0)
    lsnPadFixturePort(top "ENABLE" "MET2" 110.0 280.0)
    net=lsnPadFixturePort(top "SPARE" "MET6" 500.5)
    pad=dbCreateInst(top multi "MALT" 100:500 "R0")
    dbCreateInstTerm(net pad dbFindTermByName(multi "IO"))
    lsnPadFixturePort(top "UNMAPPED" "MET6" 550.5)
    lsnPadFixturePort(top "POWER" "MET3" 109.6)
    lsnPadFixturePort(top "GROUND" "MET3" -31.7)
    dbCreateInst(top analog "APAD" 100:0 "R0")
    dbCreateInst(top analog "APAD2" 100:250 "R0")
    dbCreateInst(top digital "DPAD" 300:0 "R0")
    dbCreateInst(top vdd "VPAD" 600:0 "R0")
    dbCreateInst(top ground "GPAD" 800:0 "R0")
    dbSave(top)
    lsnPadFixtureSource(libName "pad_top" list("A" "DATA" "ENABLE" "SPARE" "UNMAPPED" "POWER" "GROUND"))
    bare=dbOpenCellViewByType(libName "bare_core" "layout" "maskLayout" "a")
    lsnPadFixturePort(bare "A" "MET6" 39.0) dbSave(bare)
    lsnPadFixtureSource(libName "bare_core" list("A"))
    core=dbOpenCellViewByType(libName "core_child" "layout" "maskLayout" "a")
    lsnPadFixturePort(core "A" "MET6" 39.0) dbSave(core)
    lsnPadFixtureSource(libName "core_child" list("A"))
    parent=dbOpenCellViewByType(libName "assembly" "layout" "maskLayout" "a")
    dbCreateInst(parent core "CORE_X" 1000:1000 "R90")
    dbCreateInst(parent analog "PAD_X" 1200:1000 "MY")
    dbSave(parent)
    foreach(cv list(top bare core parent multi) dbClose(cv))
    lsnpState['fixture]=list(libName libPath)
    printf("Created disposable PAD integration fixture %s at %s. No production design was changed.\n" libName libPath)
    libName))
