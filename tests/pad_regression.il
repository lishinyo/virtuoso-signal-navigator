; SPDX-License-Identifier: MIT
; Integration tests: CREATE/EDIT ONLY a new disposable LSN_DEMO_PAD_ fixture.
; Requires pad_fixture.il plus the documented, already installed PAD libraries.
procedure(lsnPadAssert(condition description)
  unless(condition error("PAD regression failed: %s\n" description))
  lsnPadTestPassed=lsnPadTestPassed+1
  printf("PAD TEST OK: %s\n" description))

procedure(lsnPadTestWire(cv layer box name)
  let((net figure)
    unless(rexMatchp("^LSN_DEMO_PAD_" cv~>libName) && member(cv~>mode list("a" "w"))
      error("Test wire is allowed only in the owned disposable fixture.\n"))
    net=dbFindNetByName(cv name) unless(net net=dbCreateNet(cv name))
    figure=dbCreateRect(cv list(layer "drawing") box) dbAddFigToNet(figure net)
    figure))

procedure(lsnRunPadTests(lib path techLib)
  let((bareWin mainWin childWin parentWin cv parentCV e before other target formFile saved key
       seed trace info childBox parentBox report previousOverride inventory)
    lsnPadTestPassed=0 previousOverride=lsnCfg('sourceOverride)
    when(lsnpState['form] hiFormCancel(lsnpState['form]))
    lsnPadCreateFixture(lib path techLib)
    unwindProtect(
      progn(
        bareWin=deOpenCellView(lib "bare_core" "layout" "maskLayout" list(0:0 1600:1050) "a")
        lsnConfigure('sourceOverride list(lib "bare_core" "schematic")) lsnStart(bareWin nil)
        lsnChoose("A" nil) e=lsncEntry()
        lsnPadAssert(e['internalComplete] && e['padStatus]=="pending" && !member("Connected" e['tags])
          "internally connected schematic Pin stays pending without a PAD")
        lsnPadAssert(member("Open" e['tags]) && e['padRows] && !e['padNavigation]
          "missing PAD is an explicit obligation, with no fabricated coordinates")
        lsnState['form]->lsnCategory->value="Pin Open" lsnFilter()
        lsnPadAssert(length(lsnState['form]->lsnSignals->choices)==1 "Pin Open includes Pin still awaiting PAD")
        lsnState['form]->lsnCategory->value="Pin" lsnFilter()
        lsnPadAssert(length(lsnState['form]->lsnSignals->choices)==1 "Show still uses one schematic Pin category")
        lsnState['form]->lsnUnconnectedOnly->value=t lsnNext(1)
        lsnPadAssert(lsnState['index]==0 "pending-only navigation can visit the existing core exit")
        mainWin=deOpenCellView(lib "pad_top" "layout" "maskLayout" list(0:0 1600:1050) "a")
        lsnConfigure('sourceOverride list(lib "pad_top" "schematic")) lsnStart(mainWin nil)
        cv=lsnState['cv] lsnChoose("UNMAPPED" nil) e=lsncEntry()
        inventory=lsnpInventory()
        lsnPadAssert(length(inventory['items])==6 "actual analog/GPIO and custom PAD instances are discovered")
        lsnPadAssert(e['padStatus]=="unassigned" && member("Unverified" e['tags]) && !member("Connected" e['tags])
          "placed but unassigned PADs never prove a Pin complete")
        lsnChoose("A" nil) lsnPadBind("A" list("APAD") "IO") lsncCheckCurrent() e=lsncEntry()
        lsnPadAssert(e['padStatus]=="unconnected" && !member("Connected" e['tags])
          "correctly assigned real analog PAD still needs a physical wire")
        lsnPadAssert(length(e['padNavigation])==1 && nth(4 car(e['padNavigation]))=="PAD"
          "actual PAD contact is included in the location list")
        lsnState['form]->lsnUnconnectedOnly->value=t lsnState['index]=-1
        lsnNext(1) before=lsnState['index] lsnNext(1)
        lsnPadAssert(before==0 && lsnState['index]==length(e['corePoints])
          "pending-only cycle visits the core exit and the unconnected PAD")
        lsnPadAssert(!errset(lsnPadBind("UNMAPPED" list("APAD") "IO") nil)
          "one PAD core terminal cannot be explicitly assigned to two logical nets")
        lsnPadAssert(!errset(lsnPadBind("DATA" list("DPAD") "PAD") nil)
          "digital external PAD terminal is forbidden as the core connection target")
        lsnPadAssert(!errset(lsnPadBind("POWER" list("DPAD") "DVDD") nil)
          "GPIO supply/ESD rails are not mistaken for a power bond PAD")
        lsnPadTestWire(cv "MET6" list(10:38.7 139:39.3) "A") lsncCheckCurrent() e=lsncEntry()
        lsnPadAssert(e['internalComplete] && e['padStatus]=="connected" && member("Connected" e['tags])
          "real analog bond contact joins the core only after its wire is present")
        lsnPadAssert(!e['attention] "a completed Pin has no pending navigation targets")
        lsnChoose("DATA" nil) lsnPadBind("DATA" list("DPAD") "I") lsncCheckCurrent() e=lsncEntry()
        lsnPadAssert(member(e['padStatus] list("unconnected" "unverified")) && !member("Connected" e['tags])
          "real GPIO I cannot be reported complete before connecting; uncertain access remains unverified")
        lsnPadTestWire(cv "MET2" list(290:100.0 318.5:100.44) "DATA") lsncCheckCurrent() e=lsncEntry()
        lsnPadAssert(e['padStatus]=="connected" && member("Connected" e['tags])
          "core wire to GPIO I completes the PAD requirement without shorting to the external bond metal")
        target=car(e['padTargets])
        lsnPadAssert(length(e['padNavigation])==1 && length(target['points])>=2
          "M2/M3 access alternatives represent one required GPIO terminal")
        other=e lsnChoose("A" nil) lsncCheckCurrent()
        lsnPadAssert(lsncEntry("DATA")==other "Check selected preserves another Pin's PAD result")
        before=lsncEntry("A") lsnPadBind("A" list("APAD2") "IO")
        lsnPadAssert(!lsncEntryCurrent(before) && lsncEntryCurrent(other)
          "changing one Pin mapping invalidates only that Pin's PAD signature")
        lsncCheckCurrent() e=lsncEntry()
        lsnPadAssert(length(e['padTargets])==2 && e['padStatus]=="unconnected" && !member("Connected" e['tags])
          "all explicitly required PADs must connect; one connected target is insufficient")
        lsnPadTestWire(cv "MET6" list(138.8:39 139.2:289) "A") lsncCheckCurrent() e=lsncEntry()
        lsnPadAssert(e['padStatus]=="connected" && member("Connected" e['tags])
          "multiple required PADs complete after both physical contacts join")
        lsnChoose("SPARE" nil) e=lsncEntry()
        lsnPadAssert(e['padBindingMode]=="source/layout binding" && e['padStatus]=="unconnected"
          "actual layout instTerm net membership auto-associates intent but not physical completion")
        lsnPadAssert(!errset(lsnPadBind("UNMAPPED" list("MALT") "IO") nil)
          "explicit mapping cannot contradict an existing logical PAD assignment")
        lsnPadTestWire(cv "MET6" list(10:500.2 101:500.8) "SPARE") lsncCheckCurrent() e=lsncEntry()
        target=car(e['padTargets])
        lsnPadAssert(length(target['points])==2 && e['padStatus]=="connected" && length(e['padNavigation])==1
          "one connected access figure satisfies a terminal even if another alternative is isolated")
        lsnPadBind("SPARE" list("DPAD") "DS") lsncCheckCurrent() e=lsncEntry()
        lsnPadAssert(length(e['padTargets])==2 && !member("Connected" e['tags])
          "explicit targets supplement rather than erase existing automatic PAD obligations")
        lsnPadUnbind("SPARE" list("DPAD") "DS") lsncCheckCurrent() e=lsncEntry()
        lsnPadAssert(e['padStatus]=="connected" "removing the extra explicit target preserves the automatic one")
        lsnChoose("ENABLE" nil) lsnPadBind("ENABLE" list("DPAD") "OEN")
        lsnPadTestWire(cv "MET2" list(290:109.8 321.3:110.2) "ENABLE")
        lsnPadTestWire(cv "MET2" list(320.9:100.1 321.3:110.2) "ENABLE") lsncCheckCurrent() e=lsncEntry()
        lsnPadAssert(e['padStatus]=="connected" "another logical Pin may use a different control terminal on the same GPIO PAD")
        lsnChoose("POWER" nil) lsnPadBind("POWER" list("VPAD") "VDD")
        lsnPadTestWire(cv "MET3" list(10:109.4 676.5:109.8) "POWER") lsncCheckCurrent() e=lsncEntry()
        lsnPadAssert(e['padStatus]=="connected" "VDDPAD power rail must physically reach its real bond metal")
        lsnChoose("GROUND" nil) lsnPadBind("GROUND" list("GPAD") "GND")
        lsnPadTestWire(cv "MET3" list(10:-31.9 875.7:-31.5) "GROUND") lsncCheckCurrent() e=lsncEntry()
        lsnPadAssert(e['padStatus]=="connected" "GNDPAD ground rail must physically reach its real bond metal")
        lsnChoose("DATA" nil) lsncCheckCurrent() other=lsncEntry()
        lsnChoose("A" nil) formFile=strcat(path "/pad_roundtrip.il")
        saved=lsnpState['bindings][lsnpBindingKey("A")] lsnPadSaveConfig(formFile)
        foreach(spec saved lsnPadUnbind("A" car(spec) cadr(spec)))
        lsncCheckCurrent() e=lsncEntry()
        lsnPadAssert(e['padStatus]=="unassigned" "clearing explicit targets removes completion")
        load(formFile) lsncCheckCurrent() e=lsncEntry()
        lsnPadAssert(equal(saved lsnpState['bindings][lsnpBindingKey("A")]) && e['padStatus]=="connected"
          "saved portable PAD configuration restores mappings and proof")
        lsnPadAssert(lsncEntry("DATA")==other && lsncEntryCurrent(other)
          "loading identical PAD profiles does not invalidate another Pin")
        lsnPadAssert(!errset(lsnPadSaveConfig(formFile) nil) "configuration save refuses to overwrite an existing file")
        seed=lsncSeed(car(e['corePoints]))
        trace=lntAddTrace(mainWin car(seed) ?mode "physical" ?hierPath cadr(seed) ?stackLayers lsncStackLayers)
        lntSetTraceColor(trace "magenta" mainWin) lntSetTraceVisibility(trace 0 mainWin) info=lntGetTraceInfo(trace)
        lsncCheckCurrent() e=lsncEntry()
        lsnPadAssert(!member("Connected" e['tags]) && lntGetTraceInfo(trace)==info
          "pre-existing user trace is preserved and is not reused as a fresh PAD proof")
        lntRemoveTrace(trace mainWin) trace=nil
        childWin=deOpenCellView(lib "core_child" "layout" "maskLayout" list(0:0 1600:1050) "a")
        parentWin=deOpenCellView(lib "assembly" "layout" "maskLayout" list(0:0 1600:1050) "a")
        lsnConfigure('sourceOverride list(lib "core_child" "schematic")) lsnStart(childWin nil)
        lsnPadSetScope(parentWin list("CORE_X")) lsnPadBind("A" list("PAD_X") "IO")
        lsnChoose("A" nil) e=lsncEntry()
        lsnPadAssert(e['padStatus]=="unconnected" "PAD in a parent assembly is checked in that scope")
        parentCV=geGetEditCellView(parentWin)
        lsnPadTestWire(parentCV "MET6" list(960.5:1000.2 1162:1000.8) "A") lsncCheckCurrent() e=lsncEntry()
        lsnPadAssert(e['padStatus]=="connected" && member("Connected" e['tags])
          "parent-level wire joins rotated core and mirrored real PAD")
        childBox=hiGetViewBBox(childWin) lsnGo(length(lsnState['points])-1)
        lsnPadAssert(hiGetViewBBox(childWin)==childBox &&
          abs(xCoord(lsnCenter(hiGetViewBBox(parentWin)))-1161.015)<0.01
          "PAD location jumps to the correct parent window/coordinate")
        parentBox=hiGetViewBBox(parentWin) lsnOverview() lsnBack()
        lsnPadAssert(hiGetViewBBox(parentWin)==parentBox && lsnValid()
          "PAD-scope overview/back keeps the bound core context")
        lsnPadSetup()
        lsnPadAssert(lsnpState['form] && length(lsnpState['form]->lsnpPads->choices)==1 &&
          lsnpState['form]->lsnpCorePath->value=="CORE_X" "native PAD setup shows scope, inventory and required targets")
        hiFormCancel(lsnpState['form])
        lsnPadAssert(!boundp('lsnrState) "PAD completion does not load prediction")
        printf("PAD COMPLETION REGRESSION: %d passed.\n" lsnPadTestPassed))
      progn(
        when(trace errset(lntRemoveTrace(trace mainWin) nil))
        lsnConfig['sourceOverride]=previousOverride))
    lsnPadTestPassed))
